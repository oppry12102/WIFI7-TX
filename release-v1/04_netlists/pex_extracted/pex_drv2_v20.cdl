* PEX CDL generated by pex_to_cdl.py v5
* GDS: TX5G_M3_DRV2_V20
* Subckt: drv2
* Ports: inp, inn, outp, outn, vcc
* 提取层次: 1 (R-only)
* 电源网简化: on
* 转换五规则: X→Q / hbt_mirror 内联 / 剥 V·Cin·Ct·Lt / R→3T / sub=0
*
.lib "../models/cornerHBT.lib" hbt_typ

.subckt drv2 inp inn outp outn vcc
Q1 ccas1 bin e1 npn13G2 we=70n le=900n NX=10 M=1 sub=0
Q2 ccas2 bb1 e2 npn13G2 we=70n le=900n NX=10 M=1 sub=0
Q3 outp nbcas ccas1 npn13G2 we=70n le=900n NX=10 M=1 sub=0
Q4 outn nbcas ccas2 npn13G2 we=70n le=900n NX=10 M=1 sub=0
R1 e1 ntail rsil l=1.0u w=4.665u sub=0
R2 e2 ntail rsil l=1.0u w=4.665u sub=0
Q5 ntail nref gnd npn13G2 we=70n le=900n NX=8 M=1 sub=0
Q6 nref nref gnd npn13G2 we=70n le=900n NX=1 M=1 sub=0
R3 vcc nref rhigh l=1.19u w=1.0u sub=0
Q7 ntail nref gnd npn13G2 we=70n le=900n NX=8 M=1 sub=0
Q8 nref nref gnd npn13G2 we=70n le=900n NX=1 M=1 sub=0
R4 vcc nref rhigh l=1.19u w=1.0u sub=0
Q9 ntail nref gnd npn13G2 we=70n le=900n NX=8 M=1 sub=0
Q10 nref nref gnd npn13G2 we=70n le=900n NX=1 M=1 sub=0
R5 vcc nref rhigh l=1.19u w=1.0u sub=0
Q11 ntail nref gnd npn13G2 we=70n le=900n NX=8 M=1 sub=0
Q12 nref nref gnd npn13G2 we=70n le=900n NX=1 M=1 sub=0
R6 vcc nref rhigh l=1.19u w=1.0u sub=0
R7 inp gnd rhigh l=1.0u w=1.36u sub=0
R8 inn gnd rhigh l=1.0u w=1.36u sub=0
R9 bin nbias rppd l=1.923u w=1.0u sub=0
R10 bb1 nbias rppd l=1.923u w=1.0u sub=0
R11 vcc outp rppd l=1.0u w=2.6u sub=0
R12 vcc outn rppd l=1.0u w=2.6u sub=0
.ends drv2

* 器件统计: Q=12 R=12 C=0
* 网数: 25 匿名网: 6
