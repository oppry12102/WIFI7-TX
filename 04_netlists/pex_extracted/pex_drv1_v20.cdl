* PEX CDL generated by pex_to_cdl.py v5
* GDS: TX5G_M3_DRV1_V20
* Subckt: drv1
* Ports: inp, inn, cop, con, vcc
* 提取层次: 1 (R-only)
* 电源网简化: on
* 转换五规则: X→Q / hbt_mirror 内联 / 剥 V·Cin·Ct·Lt / R→3T / sub=0
*
.lib "../models/cornerHBT.lib" hbt_typ

.subckt drv1 inp inn cop con vcc
Q1 cop bin e1 npn13G2 we=70n le=900n NX=6 M=1 sub=0
Q2 con bb1 e2 npn13G2 we=70n le=900n NX=6 M=1 sub=0
R1 e1 ntail rsil l=1.0u w=1.75u sub=0
R2 e2 ntail rsil l=1.0u w=1.75u sub=0
Q3 ntail nref gnd npn13G2 we=70n le=900n NX=8 M=1 sub=0
Q4 nref nref gnd npn13G2 we=70n le=900n NX=1 M=1 sub=0
R3 vcc nref rhigh l=1.19u w=1.0u sub=0
R4 inp gnd rhigh l=1.0u w=1.36u sub=0
R5 inn gnd rhigh l=1.0u w=1.36u sub=0
R6 bin nbias rhigh l=1.0u w=1.36u sub=0
R7 bb1 nbias rhigh l=1.0u w=1.36u sub=0
R8 vcc cop rppd l=1.0u w=2.6u sub=0
R9 vcc con rppd l=1.0u w=2.6u sub=0
.ends drv1

* 器件统计: Q=4 R=9 C=0
* 网数: 13 匿名网: 0
