* PEX CDL generated by pex_to_cdl.py v5 (revised _resolve_net)
* GDS: TX5G_M2_MIX_V31
* SRC_GDS_SHA256: ef034d51202c2db8ebc8f78c74c798c55b90f984870181839d885d39985837c1
* Subckt: gilbert_mix
* Ports: ifp, ifn, lop, lon, rfop, rfon, vcc
* 提取层次: 1 (R + cmim；v5 起 MIM 面入提取——含 cmim 的块另出 C 件，口径见层次1_提取设置声明)
* 电源网简化: on
* 网名策略: 原名·众数优先（裁定①②）
* 转换五规则: X→Q / hbt_mirror 内联 / 剥 V·Cin·Ct·Lt / R→3T / sub=0
*
.lib "../models/cornerHBT.lib" hbt_typ

.subckt gilbert_mix ifp ifn lop lon rfop rfon vcc
Q1 nswa na1p e1a npn13G2 we=70n le=900n NX=3 M=1 sub=0
Q2 nswa nb1p e1b npn13G2 we=70n le=900n NX=3 M=1 sub=0
Q3 nswb nb2n e2b npn13G2 we=70n le=900n NX=3 M=1 sub=0
Q4 nswb na2n e2a npn13G2 we=70n le=900n NX=3 M=1 sub=0
Q5 gnd gnd gnd npn13G2 we=70n le=900n NX=3 M=1 sub=0
Q6 gnd gnd gnd npn13G2 we=70n le=900n NX=3 M=1 sub=0
R1 e1a ntaila rsil l=4.286u w=1.0u sub=0
R2 e2a ntaila rsil l=4.286u w=1.0u sub=0
R3 e1b ntailb rsil l=4.286u w=1.0u sub=0
R4 e2b ntailb rsil l=4.286u w=1.0u sub=0
Q7 ntaila nref gnd npn13G2 we=70n le=900n NX=10 M=1 sub=0
Q8 nref nref gnd npn13G2 we=70n le=900n NX=1 M=1 sub=0
R5 nvtop nref rhigh l=1.0u w=2.0u sub=0
Q9 ntailb nref gnd npn13G2 we=70n le=900n NX=10 M=1 sub=0
Q10 nref nref gnd npn13G2 we=70n le=900n NX=1 M=1 sub=0
R6 nvtop nref rhigh l=1.0u w=2.0u sub=0
Q11 rfop lopd nswa npn13G2 we=70n le=900n NX=6 M=1 sub=0
Q12 rfon lond nswa npn13G2 we=70n le=900n NX=6 M=1 sub=0
Q13 rfon lopd nswb npn13G2 we=70n le=900n NX=6 M=1 sub=0
Q14 rfop lond nswb npn13G2 we=70n le=900n NX=6 M=1 sub=0
R7 lop lopd rsil l=1.429u w=1.0u sub=0
R8 lon lond rsil l=1.429u w=1.0u sub=0
R9 na1p nbiasL rhigh l=1.47u w=1.0u sub=0
R10 nb1p nbiasH rhigh l=1.47u w=1.0u sub=0
R11 nb2n nbiasL rhigh l=1.47u w=1.0u sub=0
R12 na2n nbiasH rhigh l=1.47u w=1.0u sub=0
R13 ifp nifbias rhigh l=1.47u w=1.0u sub=0
R14 ifn nifbias rhigh l=1.47u w=1.0u sub=0
C1 na1p ifp cmim area=514.382 perim=90.72 sub=0
C2 nb2n ifn cmim area=514.382 perim=90.72 sub=0
C3 nb1p ifp cmim area=514.382 perim=90.72 sub=0
C4 na2n ifn cmim area=514.382 perim=90.72 sub=0
R15 vcc rfop rsil l=6.429u w=1.0u sub=0
R16 vcc rfon rsil l=6.429u w=1.0u sub=0
C5 rfop gnd cmim area=514.382 perim=90.72 sub=0
C6 rfon gnd cmim area=514.382 perim=90.72 sub=0
Q15 nsens nsens gnd npn13G2 we=70n le=900n NX=1 M=1 sub=0
.ends gilbert_mix

* 器件统计: Q=15 R=16 C=6
* 网数: 35 匿名网: 6
